* Auto-generated testbench for voltage divider: R437/R443
* Expected Vout = 3.3 * 0.982456 = 3.2421 V
* Model: ideal passives (exact, unloaded)

VIN SHUNT_W_SENSE_P 0 DC 3.3
R437 SHUNT_W_SENSE_P OPP_W1 1k
R443 OPP_W1 0 56k

.op

.end
