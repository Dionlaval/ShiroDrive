* Auto-generated testbench for voltage divider: R420/R442
* Expected Vout = 3.3 * 0.500000 = 1.6500 V
* Model: ideal passives (exact, unloaded)

VIN VREF_ 0 DC 3.3
R420 VREF_ OPP_V1 56k
R442 OPP_V1 0 56k

.op

.end
