* Auto-generated testbench for voltage divider: R201/R202
* Expected Vout = 5.0 * 0.199359 = 0.9968 V
* Model: ideal passives (exact, unloaded)

VIN n5V_BAT 0 DC 5.0
R201 n5V_BAT n5V_FB 100k
R202 n5V_FB 0 24.9k

.op

.end
