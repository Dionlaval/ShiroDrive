* Auto-generated testbench for regulator feedback: U205
* Divider: R216/R217, ratio=0.1603
* Expected Vout=5.0V, Vfb=0.8014V (Vref=0.6V)
* Topology: standard
* Model: ideal passives (exact for DC divider)

VIN out_rail 0 DC 5.0
R216 out_rail fb_net 34k
R217 fb_net 0 6.49k

.control
op
let vfb_sim = v(fb_net)
let expected = 0.8014300000000001
let error_pct = abs(vfb_sim - expected) / expected * 100
echo "vfb_sim=$&vfb_sim error_pct=$&error_pct expected=0.8014300000000001 vin=5.0 vref=0.6" > ShiroFOC/Manual_Rebuild/review/schematic_review_2026-09-26/spice_work/regulator-feedback_U205_R216_R217.out
quit
.endc

.end
