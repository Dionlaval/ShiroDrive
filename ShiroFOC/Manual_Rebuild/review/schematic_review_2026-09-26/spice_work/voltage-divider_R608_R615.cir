* Auto-generated testbench for voltage divider: R608/R615
* Expected Vout = 3.3 * 0.955110 = 3.1519 V
* Model: ideal passives (exact, unloaded)

VIN EXT_VCC 0 DC 3.3
R608 EXT_VCC __unnamed_68 4.7k
R615 __unnamed_68 0 100k

.control
op
let vout_sim = v(__unnamed_68)
let error_pct = abs(vout_sim - 3.151863) / 3.151863 * 100
echo "vout_sim=$&vout_sim error_pct=$&error_pct expected=3.151863" > ShiroFOC/Manual_Rebuild/review/schematic_review_2026-09-26/spice_work/voltage-divider_R608_R615.out
quit
.endc

.end
