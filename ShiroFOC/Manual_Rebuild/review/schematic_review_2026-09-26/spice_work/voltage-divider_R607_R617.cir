* Auto-generated testbench for voltage divider: R607/R617
* Expected Vout = 3.3 * 0.999001 = 3.2967 V
* Model: ideal passives (exact, unloaded)

VIN __unnamed_67 0 DC 3.3
R607 __unnamed_67 __unnamed_62 100
R617 __unnamed_62 0 100k

.control
op
let vout_sim = v(__unnamed_62)
let error_pct = abs(vout_sim - 3.2967033) / 3.2967033 * 100
echo "vout_sim=$&vout_sim error_pct=$&error_pct expected=3.2967033" > ShiroFOC/Manual_Rebuild/review/schematic_review_2026-09-26/spice_work/voltage-divider_R607_R617.out
quit
.endc

.end
