* Auto-generated testbench for voltage divider: R430/R443
* Expected Vout = 3.3 * 0.500000 = 1.6500 V
* Model: ideal passives (exact, unloaded)

VIN VREF_ 0 DC 3.3
R430 VREF_ OPP_W1 56k
R443 OPP_W1 0 56k

.control
op
let vout_sim = v(OPP_W1)
let error_pct = abs(vout_sim - 1.65) / 1.65 * 100
echo "vout_sim=$&vout_sim error_pct=$&error_pct expected=1.65" > ShiroFOC/Manual_Rebuild/review/schematic_review_2026-09-26/spice_work/voltage-divider_R430_R443.out
quit
.endc

.end
