* Auto-generated testbench for RC filter: R303/C310
* Type: low-pass, expected fc = 15.9 Hz
* Model: ideal passives (exact for RC)

R303 n3V3 NRST 100k

C310 NRST 0 100n

* AC stimulus
VAC n3V3 0 DC 0 AC 1

.control
ac dec 100 159.2m 1.592k
meas ac fc_sim when vdb(NRST)=-3
meas ac phase_fc find vp(NRST) at=fc_sim
echo "fc_sim=$&fc_sim phase_fc=$&phase_fc has_parasitics=0" > ShiroFOC/Manual_Rebuild/review/schematic_review_2026-09-26/spice_work/rc-filter_R303_C310.out
quit
.endc

.end
