* Auto-generated testbench for voltage divider: R212/R213
* Expected Vout = 5.0 * 0.195402 = 0.9770 V
* Model: ideal passives (exact, unloaded)

VIN n5V_USB 0 DC 5.0
R212 n5V_USB __unnamed_44 21k
R213 __unnamed_44 0 5.1k

.control
op
let vout_sim = v(__unnamed_44)
let error_pct = abs(vout_sim - 0.9770099999999999) / 0.9770099999999999 * 100
echo "vout_sim=$&vout_sim error_pct=$&error_pct expected=0.9770099999999999" > ShiroFOC/Manual_Rebuild/review/schematic_review_2026-09-26/spice_work/voltage-divider_R212_R213.out
quit
.endc

.end
