* Auto-generated testbench for voltage divider: R206/R207
* Expected Vout = 5.0 * 0.253731 = 1.2687 V
* Model: ideal passives (exact, unloaded)

VIN n5V_BAT 0 DC 5.0
R206 n5V_BAT __unnamed_48 15k
R207 __unnamed_48 0 5.1k

.control
op
let vout_sim = v(__unnamed_48)
let error_pct = abs(vout_sim - 1.2686549999999999) / 1.2686549999999999 * 100
echo "vout_sim=$&vout_sim error_pct=$&error_pct expected=1.2686549999999999" > ShiroFOC/Manual_Rebuild/review/schematic_review_2026-09-26/spice_work/voltage-divider_R206_R207.out
quit
.endc

.end
