* Auto-generated testbench for voltage divider: R216/R217
* Expected Vout = 5.0 * 0.160286 = 0.8014 V
* Model: ideal passives (exact, unloaded)

VIN n5V_BAT 0 DC 5.0
R216 n5V_BAT __unnamed_49 34k
R217 __unnamed_49 0 6.49k

.control
op
let vout_sim = v(__unnamed_49)
let error_pct = abs(vout_sim - 0.8014300000000001) / 0.8014300000000001 * 100
echo "vout_sim=$&vout_sim error_pct=$&error_pct expected=0.8014300000000001" > ShiroFOC/Manual_Rebuild/review/schematic_review_2026-09-26/spice_work/voltage-divider_R216_R217.out
quit
.endc

.end
