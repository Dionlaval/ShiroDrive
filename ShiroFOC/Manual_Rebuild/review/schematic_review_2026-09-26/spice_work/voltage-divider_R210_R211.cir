* Auto-generated testbench for voltage divider: R210/R211
* Expected Vout = 5.0 * 0.195402 = 0.9770 V
* Model: ideal passives (exact, unloaded)

VIN n5V_BAT 0 DC 5.0
R210 n5V_BAT __unnamed_43 21k
R211 __unnamed_43 0 5.1k

.control
op
let vout_sim = v(__unnamed_43)
let error_pct = abs(vout_sim - 0.9770099999999999) / 0.9770099999999999 * 100
echo "vout_sim=$&vout_sim error_pct=$&error_pct expected=0.9770099999999999" > ShiroFOC/Manual_Rebuild/review/schematic_review_2026-09-26/spice_work/voltage-divider_R210_R211.out
quit
.endc

.end
