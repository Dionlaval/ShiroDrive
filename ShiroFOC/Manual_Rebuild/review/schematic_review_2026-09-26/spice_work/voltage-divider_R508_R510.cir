* Auto-generated testbench for voltage divider: R508/R510
* Expected Vout = 3.3 * 0.689655 = 2.2759 V
* Model: ideal passives (exact, unloaded)

VIN VM 0 DC 3.3
R508 VM __unnamed_25 450k
R510 __unnamed_25 0 1Meg

.control
op
let vout_sim = v(__unnamed_25)
let error_pct = abs(vout_sim - 2.2758615) / 2.2758615 * 100
echo "vout_sim=$&vout_sim error_pct=$&error_pct expected=2.2758615" > ShiroFOC/Manual_Rebuild/review/schematic_review_2026-09-26/spice_work/voltage-divider_R508_R510.out
quit
.endc

.end
