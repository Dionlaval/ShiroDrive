* Auto-generated testbench for voltage divider: R208/R209
* Expected Vout = 5.0 * 0.337748 = 1.6887 V
* Model: ideal passives (exact, unloaded)

VIN n5V_USB 0 DC 5.0
R208 n5V_USB __unnamed_45 10k
R209 __unnamed_45 0 5.1k

.control
op
let vout_sim = v(__unnamed_45)
let error_pct = abs(vout_sim - 1.68874) / 1.68874 * 100
echo "vout_sim=$&vout_sim error_pct=$&error_pct expected=1.68874" > ShiroFOC/Manual_Rebuild/review/schematic_review_2026-09-26/spice_work/voltage-divider_R208_R209.out
quit
.endc

.end
