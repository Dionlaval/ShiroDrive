* Auto-generated testbench for RC filter: R438/C434
* Type: RC-network, expected fc = 3386275.4 Hz
* Model: ideal passives (exact for RC)

R438 OPN_W1 SHUNT_W_SENSE_N 1k

C434 SHUNT_W_SENSE_N 0 47p

* AC stimulus
VAC OPN_W1 0 DC 0 AC 1

.ac dec 100 33.86k 338.6Meg
.meas ac fc_sim when vdb(SHUNT_W_SENSE_N)=-3
.meas ac phase_fc find vp(SHUNT_W_SENSE_N) at=fc_sim

.end
