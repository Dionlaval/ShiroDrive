* Auto-generated testbench for RC filter: R428/C424
* Type: RC-network, expected fc = 3386275.4 Hz
* Model: ideal passives (exact for RC)

R428 OPN_V1 SHUNT_V_SENSE_N 1k

C424 SHUNT_V_SENSE_N 0 47p

* AC stimulus
VAC OPN_V1 0 DC 0 AC 1

.ac dec 100 33.86k 338.6Meg
.meas ac fc_sim when vdb(SHUNT_V_SENSE_N)=-3
.meas ac phase_fc find vp(SHUNT_V_SENSE_N) at=fc_sim

.end
