* Auto-generated testbench for voltage divider: R417/R441
* Expected Vout = 3.3 * 0.982456 = 3.2421 V
* Model: ideal passives (exact, unloaded)

VIN LS_SOURCE_U 0 DC 3.3
R417 LS_SOURCE_U OPP_U1 1k
R441 OPP_U1 0 56k

.op

.end
