* Auto-generated testbench for voltage divider: R216/R217
* Expected Vout = 5.0 * 0.160286 = 0.8014 V
* Model: ideal passives (exact, unloaded)

VIN n5V_BAT 0 DC 5.0
R216 n5V_BAT __unnamed_58 34k
R217 __unnamed_58 0 6.49k

.op

.end
