* Auto-generated testbench for voltage divider: R210/R211
* Expected Vout = 5.0 * 0.188192 = 0.9410 V
* Model: ideal passives (exact, unloaded)

VIN n5V_BAT 0 DC 5.0
R210 n5V_BAT __unnamed_52 22k
R211 __unnamed_52 0 5.1k

.op

.end
