* Auto-generated testbench for voltage divider: R218/R219
* Expected Vout = 3.3 * 0.500000 = 1.6500 V
* Model: ideal passives (exact, unloaded)

VIN VCC 0 DC 3.3
R218 VCC n10V_GOOD 100k
R219 n10V_GOOD 0 100k

.op

.end
