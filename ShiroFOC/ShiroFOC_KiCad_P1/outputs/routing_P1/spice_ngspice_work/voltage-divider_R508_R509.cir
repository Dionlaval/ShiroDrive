* Auto-generated testbench for voltage divider: R508/R509
* Expected Vout = 3.3 * 0.027448 = 0.0906 V
* Model: ideal passives (exact, unloaded)

VIN VM 0 DC 3.3
R508 VM __unnamed_59 450k
R509 __unnamed_59 0 12.7k

.control
op
let vout_sim = v(__unnamed_59)
let error_pct = abs(vout_sim - 0.09057839999999999) / 0.09057839999999999 * 100
echo "vout_sim=$&vout_sim error_pct=$&error_pct expected=0.09057839999999999" > /Users/dionlava/Documents/GitHub/ShiroDrive/ShiroFOC/ShiroFOC_KiCad_P1/outputs/routing_P1/spice_ngspice_work/voltage-divider_R508_R509.out
quit
.endc

.end
