* Auto-generated testbench for voltage divider: R210/R211
* Expected Vout = 5.0 * 0.195402 = 0.9770 V
* Model: ideal passives (exact, unloaded)

VIN n5V_BAT 0 DC 5.0
R210 n5V_BAT __unnamed_9 21k
R211 __unnamed_9 0 5.1k

.control
op
let vout_sim = v(__unnamed_9)
let error_pct = abs(vout_sim - 0.9770099999999999) / 0.9770099999999999 * 100
echo "vout_sim=$&vout_sim error_pct=$&error_pct expected=0.9770099999999999" > /Users/dionlava/Documents/GitHub/ShiroDrive/ShiroFOC/ShiroFOC_KiCad_P1/outputs/routing_P1/spice_ngspice_work/voltage-divider_R210_R211.out
quit
.endc

.end
