* Auto-generated testbench for voltage divider: R208/R209
* Expected Vout = 5.0 * 0.337748 = 1.6887 V
* Model: ideal passives (exact, unloaded)

VIN n5V_USB 0 DC 5.0
R208 n5V_USB __unnamed_10 10k
R209 __unnamed_10 0 5.1k

.control
op
let vout_sim = v(__unnamed_10)
let error_pct = abs(vout_sim - 1.68874) / 1.68874 * 100
echo "vout_sim=$&vout_sim error_pct=$&error_pct expected=1.68874" > /Users/dionlava/Documents/GitHub/ShiroDrive/ShiroFOC/ShiroFOC_KiCad_P1/outputs/routing_P1/spice_ngspice_work/voltage-divider_R208_R209.out
quit
.endc

.end
