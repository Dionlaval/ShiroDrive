* Auto-generated testbench for voltage divider: R510/R509
* Expected Vout = 3.3 * 0.012541 = 0.0414 V
* Model: ideal passives (exact, unloaded)

VIN BRAKE_OV_CMD 0 DC 3.3
R510 BRAKE_OV_CMD __unnamed_59 1Meg
R509 __unnamed_59 0 12.7k

.control
op
let vout_sim = v(__unnamed_59)
let error_pct = abs(vout_sim - 0.0413853) / 0.0413853 * 100
echo "vout_sim=$&vout_sim error_pct=$&error_pct expected=0.0413853" > /Users/dionlava/Documents/GitHub/ShiroDrive/ShiroFOC/ShiroFOC_KiCad_P1/outputs/routing_P1/spice_ngspice_work/voltage-divider_R510_R509.out
quit
.endc

.end
