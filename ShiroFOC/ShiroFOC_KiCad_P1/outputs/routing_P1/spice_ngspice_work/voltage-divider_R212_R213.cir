* Auto-generated testbench for voltage divider: R212/R213
* Expected Vout = 5.0 * 0.195402 = 0.9770 V
* Model: ideal passives (exact, unloaded)

VIN n5V_USB 0 DC 5.0
R212 n5V_USB __unnamed_11 21k
R213 __unnamed_11 0 5.1k

.control
op
let vout_sim = v(__unnamed_11)
let error_pct = abs(vout_sim - 0.9770099999999999) / 0.9770099999999999 * 100
echo "vout_sim=$&vout_sim error_pct=$&error_pct expected=0.9770099999999999" > /Users/dionlava/Documents/GitHub/ShiroDrive/ShiroFOC/ShiroFOC_KiCad_P1/outputs/routing_P1/spice_ngspice_work/voltage-divider_R212_R213.out
quit
.endc

.end
