* Auto-generated testbench for voltage divider: R312/R311
* Expected Vout = 3.3 * 0.909091 = 3.0000 V
* Model: ideal passives (exact, unloaded)

VIN __unnamed_25 0 DC 3.3
R312 __unnamed_25 __unnamed_28 1k
R311 __unnamed_28 0 10k

.op

.end
