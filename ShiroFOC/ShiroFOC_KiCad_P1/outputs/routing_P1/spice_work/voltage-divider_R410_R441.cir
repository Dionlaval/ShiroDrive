* Auto-generated testbench for voltage divider: R410/R441
* Expected Vout = 3.3 * 0.500000 = 1.6500 V
* Model: ideal passives (exact, unloaded)

VIN VREF_ 0 DC 3.3
R410 VREF_ OPP_U1 56k
R441 OPP_U1 0 56k

.op

.end
