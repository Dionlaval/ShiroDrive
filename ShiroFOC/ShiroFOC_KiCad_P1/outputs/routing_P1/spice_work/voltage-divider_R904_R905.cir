* Auto-generated testbench for voltage divider: R904/R905
* Expected Vout = 5.0 * 0.682471 = 3.4124 V
* Model: ideal passives (exact, unloaded)

VIN n5V_USB_RAW 0 DC 5.0
R904 n5V_USB_RAW CP2102_VBUS_SENSE 22.1k
R905 CP2102_VBUS_SENSE 0 47.5k

.op

.end
